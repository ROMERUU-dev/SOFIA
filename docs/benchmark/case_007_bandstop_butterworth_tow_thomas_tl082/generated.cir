* SOFIA Filter Studio generated netlist
* Topology request: tow_thomas
* Filter kind: bandstop
* Approximation: butterworth
* Filter order: 8
* Epsilon: 0.50884714
.include "../../../resources/models/TL082.cir"

* polarizacion de tierra virtual: fuente unica de 15 V, tierra virtual en 7.5 V
Vin IN 0 DC 7.5 AC 1
VTIERRA VREF 0 7.5V
VCC VCC 0 DC 15
RLOAD OUT 0 100k

* Stage 1: bandstop, f0=1408.70832 Hz, Q=3.50526, order=2
* Stage input: IN
* Stage output: 11
* Tow-Thomas con las relaciones del legado R = 1/(C*w0) y Rq = Q*R.
* Rechaza banda con alimentación directa Cff = C y Rff = R*(w0/wz)^2; la muesca queda al centro de la banda.
Xao11 VREF 21 VCC 0 11 TL082
Xao21 VREF 41 VCC 0 51 TL082
Xao31 VREF 61 VCC 0 71 TL082
c11 21 11 1.000000000e-07
c21 41 51 1.000000000e-07
r21 71 21 1130.000000
r31 11 41 1130.000000
r41 21 11 3920.000000
r51 51 61 1130.000000
r61 61 71 1130.000000
c31 IN 21 1.000000000e-07
r71 IN 41 2320.000000

* Stage 2: bandstop, f0=1152.72231 Hz, Q=1.37923, order=2
* Stage input: 11
* Stage output: 12
* Tow-Thomas con las relaciones del legado R = 1/(C*w0) y Rq = Q*R.
* Rechaza banda con alimentación directa Cff = C y Rff = R*(w0/wz)^2; la muesca queda al centro de la banda.
* Capacitor de la etapa ajustado de 1.000e-07 F a 8.200e-08 F.
Xao12 VREF 22 VCC 0 12 TL082
Xao22 VREF 42 VCC 0 52 TL082
Xao32 VREF 62 VCC 0 72 TL082
c12 22 12 8.200000000e-08
c22 42 52 8.200000000e-08
r22 72 22 1690.000000
r32 12 42 1690.000000
r42 22 12 2320.000000
r52 52 62 1690.000000
r62 62 72 1690.000000
c32 11 22 8.200000000e-08
r72 11 42 2320.000000

* Stage 3: bandstop, f0=832.81116 Hz, Q=1.37923, order=2
* Stage input: 12
* Stage output: 13
* Tow-Thomas con las relaciones del legado R = 1/(C*w0) y Rq = Q*R.
* Rechaza banda con alimentación directa Cff = C y Rff = R*(w0/wz)^2; la muesca queda al centro de la banda.
Xao13 VREF 23 VCC 0 13 TL082
Xao23 VREF 43 VCC 0 53 TL082
Xao33 VREF 63 VCC 0 73 TL082
c13 23 13 1.000000000e-07
c23 43 53 1.000000000e-07
r23 73 23 1910.000000
r33 13 43 1910.000000
r43 23 13 2610.000000
r53 53 63 1910.000000
r63 63 73 1910.000000
c33 12 23 1.000000000e-07
r73 12 43 1370.000000

* Stage 4: bandstop, f0=681.47535 Hz, Q=3.50526, order=2
* Stage input: 13
* Stage output: OUT
* Tow-Thomas con las relaciones del legado R = 1/(C*w0) y Rq = Q*R.
* Rechaza banda con alimentación directa Cff = C y Rff = R*(w0/wz)^2; la muesca queda al centro de la banda.
* Capacitor de la etapa ajustado de 1.000e-07 F a 1.800e-07 F.
Xao14 VREF 24 VCC 0 OUT TL082
Xao24 VREF 44 VCC 0 54 TL082
Xao34 VREF 64 VCC 0 74 TL082
c14 24 OUT 1.800000000e-07
c24 44 54 1.800000000e-07
r24 74 24 1300.000000
r34 OUT 44 1300.000000
r44 24 OUT 4530.000000
r54 54 64 1300.000000
r64 64 74 1300.000000
c34 13 24 1.800000000e-07
r74 13 44 634.000000

* punto de operacion inicial en la tierra virtual
.nodeset V(11)=7.5 V(51)=7.5 V(71)=7.5 V(12)=7.5 V(52)=7.5 V(72)=7.5 V(13)=7.5 V(53)=7.5
+ V(73)=7.5 V(OUT)=7.5 V(54)=7.5 V(74)=7.5

.ac dec 100 60 16000
.probe V(OUT)
.end
