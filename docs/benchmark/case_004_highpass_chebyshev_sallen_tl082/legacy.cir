* Netlist capturado del SOFIA original (Sofia.exe) con scripts/legacy_capture.py
* El editor de SOFIA pega el modelo del opamp desde el portapapeles; aqui se referencia con .include
.include "../../../resources/models/TL082.cir"
*polarizacion de tierra virtual
vin 10 0  dc 2.5 ac 1
vtierra 100 0 2.5V
*Primer Bicuadratico
Xao11 31 41 50 0 11 Tl082
c11 10 21 1.000000e-07
c21 21 31 1.000000e-07
r31 31 100 8.200000e+02
r41 21 11 8.200000e+02
r11 41 100 1.000000e+03
r21 41 11 1.800000e+03
Xao12 32 42 50 0 12 Tl082
c12 11 22 1.000000e-07
c22 22 32 1.000000e-07
r32 32 100 5.100000e+02
r42 22 12 5.100000e+02
r12 42 100 1.000000e+03
r22 42 12 1.300000e+03
Xao13 100 83 50 0 93 Tl082
r23 83 93 0.000000e+00
r13 12 73 0.000000e+00
c13 73 83 1.000000e-07

*polarizacion del opamp
vdd 50 0 dc 5
.ac dec 100 1Hz 500Hz
.probe
.end
