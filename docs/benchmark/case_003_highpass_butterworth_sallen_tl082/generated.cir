* SOFIA Filter Studio generated netlist
* Topology request: sallen_key
* Filter kind: highpass
* Approximation: butterworth
* Filter order: 8
* Epsilon: 0.50884714
.include "../../../resources/models/TL082.cir"

* polarizacion de tierra virtual: fuente unica de 15 V, tierra virtual en 7.5 V
Vin IN 0 DC 7.5 AC 1
VTIERRA VREF 0 7.5V
VCC VCC 0 DC 15
RLOAD OUT 0 100k

* Stage 1: highpass, f0=1807.90393 Hz, Q=2.56292, order=2
* Stage input: IN
* Stage output: 11
* Sallen-Key de componentes iguales con la relación del legado Av = 3 - 1/Q.
* Capacitor de la etapa ajustado de 1.000e-07 F a 3.300e-08 F.
Xao11 31 41 VCC 0 11 TL082
c11 IN 21 3.300000000e-08
c21 21 31 3.300000000e-08
r31 21 11 2670.000000
r41 31 VREF 2670.000000
r11 41 VREF 1870.000000
r21 41 11 3010.000000

* Stage 2: highpass, f0=1807.90393 Hz, Q=0.89998, order=2
* Stage input: 11
* Stage output: 12
* Sallen-Key de componentes iguales con la relación del legado Av = 3 - 1/Q.
* Capacitor de la etapa ajustado de 1.000e-07 F a 3.300e-08 F.
Xao12 32 42 VCC 0 12 TL082
c12 11 22 3.300000000e-08
c22 22 32 3.300000000e-08
r32 22 12 2670.000000
r42 32 VREF 2670.000000
r12 42 VREF 2610.000000
r22 42 12 2320.000000

* Stage 3: highpass, f0=1807.90393 Hz, Q=0.60134, order=2
* Stage input: 12
* Stage output: 13
* Sallen-Key de componentes iguales con la relación del legado Av = 3 - 1/Q.
* Capacitor de la etapa ajustado de 1.000e-07 F a 3.300e-08 F.
Xao13 33 43 VCC 0 13 TL082
c13 12 23 3.300000000e-08
c23 23 33 3.300000000e-08
r33 23 13 2670.000000
r43 33 VREF 2670.000000
r13 43 VREF 3400.000000
r23 43 13 1150.000000

* Stage 4: highpass, f0=1807.90393 Hz, Q=0.50980, order=2
* Stage input: 13
* Stage output: OUT
* Sallen-Key de componentes iguales con la relación del legado Av = 3 - 1/Q.
* Capacitor de la etapa ajustado de 1.000e-07 F a 3.300e-08 F.
Xao14 34 44 VCC 0 OUT TL082
c14 13 24 3.300000000e-08
c24 24 34 3.300000000e-08
r34 24 OUT 2670.000000
r44 34 VREF 2670.000000
r14 44 VREF 1020.000000
r24 44 OUT 39.200000

* punto de operacion inicial en la tierra virtual
.nodeset V(11)=7.5 V(12)=7.5 V(13)=7.5 V(OUT)=7.5

.ac dec 100 100 20000
.probe V(OUT)
.end
