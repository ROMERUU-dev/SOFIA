* SOFIA Filter Studio generated netlist
* Topology request: mfb
* Filter kind: bandpass
* Approximation: butterworth
* Filter order: 8
* Epsilon: 0.50884714
.include "../../../resources/models/TL082.cir"

* polarizacion de tierra virtual: fuente unica de 15 V, tierra virtual en 7.5 V
Vin IN 0 DC 7.5 AC 1
VTIERRA VREF 0 7.5V
VCC VCC 0 DC 15
RLOAD OUT 0 100k

* Stage 1: bandpass, f0=1223.79119 Hz, Q=5.54029, order=2
* Stage input: IN
* Stage output: 11
* MFB band-pass synthesis: R1 = 2Q/(C*w0) feedback, R3 = Q/(G*C*w0) input, R2 = Q/((2Q^2-G)*C*w0) shunt.
Xao11 VREF 31 VCC 0 11 TL082
c11 21 31 1.000000000e-08
c21 21 11 1.000000000e-08
* R1: series array for target 144103.766560 ohm
r11_1 31 r11_MID1 24000.000000
r11_2 r11_MID1 11 120000.000000
* R2: series array for target 1227.216371 ohm
r21_1 21 r21_MID1 27.000000
r21_2 r21_MID1 VREF 1200.000000
* R3: parallel array for target 26905.140802 ohm
r31_1 IN 21 27000.000000
r31_2 IN 21 7500000.000000

* Stage 2: bandpass, f0=1077.13964 Hz, Q=2.24933, order=2
* Stage input: 11
* Stage output: 12
* MFB band-pass synthesis: R1 = 2Q/(C*w0) feedback, R3 = Q/(G*C*w0) input, R2 = Q/((2Q^2-G)*C*w0) shunt.
* Stage capacitor auto-tuned from 1.000e-08 F to 1.000e-09 F.
Xao12 VREF 32 VCC 0 12 TL082
c12 22 32 1.000000000e-09
c22 22 12 1.000000000e-09
* R1: parallel array for target 664707.448795 ohm
r12_1 32 12 680000.000000
r12_2 32 12 30000000.000000
* R2: series array for target 36798.641257 ohm
r22_1 22 r22_MID1 6800.000000
r22_2 r22_MID1 VREF 30000.000000
* R3: series array for target 305682.503523 ohm
r32_1 11 r32_MID1 5600.000000
r32_2 r32_MID1 22 300000.000000

* Stage 3: bandpass, f0=891.24934 Hz, Q=2.24933, order=2
* Stage input: 12
* Stage output: 13
* MFB band-pass synthesis: R1 = 2Q/(C*w0) feedback, R3 = Q/(G*C*w0) input, R2 = Q/((2Q^2-G)*C*w0) shunt.
Xao13 VREF 33 VCC 0 13 TL082
c13 23 33 1.000000000e-08
c23 23 13 1.000000000e-08
* R1: parallel array for target 80334.728820 ohm
r13_1 33 13 82000.000000
r13_2 33 13 3900000.000000
* R2: parallel array for target 4447.383389 ohm
r23_1 23 VREF 4700.000000
r23_2 23 VREF 82000.000000
* R3: series array for target 36943.953419 ohm
r33_1 12 r33_MID1 910.000000
r33_2 r33_MID1 23 36000.000000

* Stage 4: bandpass, f0=784.44755 Hz, Q=5.54029, order=2
* Stage input: 13
* Stage output: OUT
* MFB band-pass synthesis: R1 = 2Q/(C*w0) feedback, R3 = Q/(G*C*w0) input, R2 = Q/((2Q^2-G)*C*w0) shunt.
Xao14 VREF 34 VCC 0 OUT TL082
c14 24 34 1.000000000e-08
c24 24 OUT 1.000000000e-08
* R1: series array for target 224811.614041 ohm
r14_1 34 r14_MID1 4700.000000
r14_2 r14_MID1 OUT 220000.000000
* R2: parallel array for target 1914.540471 ohm
r24_1 24 VREF 2000.000000
r24_2 24 VREF 43000.000000
* R3: parallel array for target 41973.837840 ohm
r34_1 13 24 62000.000000
r34_2 13 24 130000.000000

* punto de operacion inicial en la tierra virtual
.nodeset V(11)=7.5 V(12)=7.5 V(13)=7.5 V(OUT)=7.5

.ac dec 100 50 20000
.probe V(OUT)
.end
