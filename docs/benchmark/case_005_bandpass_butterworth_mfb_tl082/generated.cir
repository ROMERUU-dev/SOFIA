* SOFIA Filter Studio generated netlist
* Topology request: mfb
* Filter kind: bandpass
* Approximation: butterworth
* Filter order: 8
* Epsilon: 0.50884714
.include "../../../resources/models/TL082.cir"

* polarizacion de tierra virtual: fuente unica de 15 V, tierra virtual en 7.5 V
Vin IN 0 DC 7.5 AC 1
VTIERRA VREF 0 7.5V
VCC VCC 0 DC 15
RLOAD OUT 0 100k

* Stage 1: bandpass, f0=1257.79398 Hz, Q=4.95823, order=2
* Stage input: IN
* Stage output: 11
* MFB pasa banda: R1 = 2Q/(C*w0) de realimentación, R3 = Q/(G*C*w0) de entrada, R2 = Q/((2Q^2-G)*C*w0) a tierra.
* Capacitor de la etapa ajustado de 1.000e-08 F a 1.800e-08 F.
Xao11 VREF 31 VCC 0 11 TL082
c11 21 31 1.800000000e-08
c21 21 11 1.800000000e-08
r11 31 11 69800.000000
r21 21 VREF 750.000000
r31 IN 21 13000.000000

* Stage 2: bandpass, f0=1090.66650 Hz, Q=2.00278, order=2
* Stage input: 11
* Stage output: 12
* MFB pasa banda: R1 = 2Q/(C*w0) de realimentación, R3 = Q/(G*C*w0) de entrada, R2 = Q/((2Q^2-G)*C*w0) a tierra.
* Capacitor de la etapa ajustado de 1.000e-08 F a 1.500e-08 F.
Xao12 VREF 32 VCC 0 12 TL082
c12 22 32 1.500000000e-08
c22 22 12 1.500000000e-08
r12 32 12 39200.000000
r22 22 VREF 2800.000000
r32 11 22 17800.000000

* Stage 3: bandpass, f0=880.19573 Hz, Q=2.00278, order=2
* Stage input: 12
* Stage output: 13
* MFB pasa banda: R1 = 2Q/(C*w0) de realimentación, R3 = Q/(G*C*w0) de entrada, R2 = Q/((2Q^2-G)*C*w0) a tierra.
* Capacitor de la etapa ajustado de 1.000e-08 F a 6.800e-09 F.
Xao13 VREF 33 VCC 0 13 TL082
c13 23 33 6.800000000e-09
c23 23 13 6.800000000e-09
r13 33 13 107000.000000
r23 23 VREF 7680.000000
r33 12 23 48700.000000

* Stage 4: bandpass, f0=763.24105 Hz, Q=4.95823, order=2
* Stage input: 13
* Stage output: OUT
* MFB pasa banda: R1 = 2Q/(C*w0) de realimentación, R3 = Q/(G*C*w0) de entrada, R2 = Q/((2Q^2-G)*C*w0) a tierra.
* Capacitor de la etapa ajustado de 1.000e-08 F a 2.700e-08 F.
Xao14 VREF 34 VCC 0 OUT TL082
c14 24 34 2.700000000e-08
c24 24 OUT 2.700000000e-08
r14 34 OUT 76800.000000
r24 24 VREF 825.000000
r34 13 24 14300.000000

* punto de operacion inicial en la tierra virtual
.nodeset V(11)=7.5 V(12)=7.5 V(13)=7.5 V(OUT)=7.5

.ac dec 100 50 20000
.probe V(OUT)
.end
