* SOFIA Filter Studio generated netlist
* Topology request: sallen_key
* Filter kind: bandpass
* Approximation: chebyshev
* Filter order: 6
* Epsilon: 0.50884714
.include "../../../resources/models/TL082.cir"

* polarizacion de tierra virtual: fuente unica de 15 V, tierra virtual en 7.5 V
Vin IN 0 DC 7.5 AC 1
VTIERRA VREF 0 7.5V
VCC VCC 0 DC 15
RLOAD OUT 0 100k

* Stage 1: bandpass, f0=1192.14472 Hz, Q=10.10489, order=2
* Stage input: IN
* Stage output: 11
* Equal-C, equal-R Sallen-Key band-pass with K = 4 - sqrt(2)/Q and center gain K/(4 - K).
* Q = 10.10 makes this Sallen-Key band-pass very sensitive to resistor tolerance and op amp bandwidth; MFB or Tow-Thomas is more robust.
* Input divider R1a/R1b (Thevenin = R1) scales the peak gain from 27.58 to 4.113.
* Stage capacitor auto-tuned from 1.000e-08 F to 1.000e-06 F.
Xao11 31 41 VCC 0 11 TL082
* R1a: parallel array for target 1265.964263 ohm
r31_1 IN 21 1300.000000
r31_2 IN 21 47000.000000
* R1b: series array for target 221.894423 ohm
r61_1 21 r61_MID1 1.800000
r61_2 r61_MID1 VREF 220.000000
c11 21 VREF 1.000000000e-06
c21 21 31 1.000000000e-06
* R2: parallel array for target 188.801808 ohm
r41_1 21 11 300.000000
r41_2 21 11 510.000000
* R3: parallel array for target 188.801808 ohm
r51_1 31 VREF 300.000000
r51_2 31 VREF 510.000000
r11 41 VREF 10000.000000
* Rf: series array for target 28600.466316 ohm
r21_1 41 r21_MID1 1600.000000
r21_2 r21_MID1 11 27000.000000

* Stage 2: bandpass, f0=979.79590 Hz, Q=4.95677, order=2
* Stage input: 11
* Stage output: 12
* Equal-C, equal-R Sallen-Key band-pass with K = 4 - sqrt(2)/Q and center gain K/(4 - K).
* Input divider R1a/R1b (Thevenin = R1) scales the peak gain from 13.02 to 1.000.
* Stage capacitor auto-tuned from 1.000e-08 F to 1.000e-06 F.
Xao12 32 42 VCC 0 12 TL082
* R1a: parallel array for target 2990.927345 ohm
r32_1 11 22 3000.000000
r32_2 11 22 910000.000000
* R1b: series array for target 248.832106 ohm
r62_1 22 r62_MID1 9.100000
r62_2 r62_MID1 VREF 240.000000
c12 22 VREF 1.000000000e-06
c22 22 32 1.000000000e-06
* R2: parallel array for target 229.720373 ohm
r42_1 22 12 390.000000
r42_2 22 12 560.000000
* R3: parallel array for target 229.720373 ohm
r52_1 32 VREF 390.000000
r52_2 32 VREF 560.000000
r12 42 VREF 10000.000000
* Rf: series array for target 27146.904682 ohm
r22_1 42 r22_MID1 150.000000
r22_2 r22_MID1 12 27000.000000

* Stage 3: bandpass, f0=805.27136 Hz, Q=10.10489, order=2
* Stage input: 12
* Stage output: OUT
* Equal-C, equal-R Sallen-Key band-pass with K = 4 - sqrt(2)/Q and center gain K/(4 - K).
* Q = 10.10 makes this Sallen-Key band-pass very sensitive to resistor tolerance and op amp bandwidth; MFB or Tow-Thomas is more robust.
* Input divider R1a/R1b (Thevenin = R1) scales the peak gain from 27.58 to 4.113.
* Stage capacitor auto-tuned from 1.000e-08 F to 1.000e-06 F.
Xao13 33 43 VCC 0 OUT TL082
* R1a: series array for target 1874.166516 ohm
r33_1 12 r33_MID1 75.000000
r33_2 r33_MID1 23 1800.000000
* R1b: parallel array for target 328.498292 ohm
r63_1 23 VREF 330.000000
r63_2 23 VREF 75000.000000
c13 23 VREF 1.000000000e-06
c23 23 33 1.000000000e-06
* R2: parallel array for target 279.507121 ohm
r43_1 23 OUT 510.000000
r43_2 23 OUT 620.000000
* R3: parallel array for target 279.507121 ohm
r53_1 33 VREF 510.000000
r53_2 33 VREF 620.000000
r13 43 VREF 10000.000000
* Rf: series array for target 28600.466316 ohm
r23_1 43 r23_MID1 1600.000000
r23_2 r23_MID1 OUT 27000.000000

* punto de operacion inicial en la tierra virtual
.nodeset V(11)=7.5 V(12)=7.5 V(OUT)=7.5

.ac dec 100 50 20000
.probe V(OUT)
.end
