* SOFIA Filter Studio generated netlist
* Topology request: sallen_key
* Filter kind: lowpass
* Approximation: butterworth
* Filter order: 8
* Epsilon: 0.50884714
.include "../../../resources/models/oplm324.cir"

* polarizacion de tierra virtual: fuente unica de 5 V, tierra virtual en 2.5 V
Vin IN 0 DC 2.5 AC 1
VTIERRA VREF 0 2.5V
VCC VCC 0 DC 5
RLOAD OUT 0 100k

* Stage 1: lowpass, f0=1106.25347 Hz, Q=2.56292, order=2
* Stage input: IN
* Stage output: 11
* Sallen-Key de componentes iguales con la relación del legado Av = 3 - 1/Q.
* Capacitor de la etapa ajustado de 1.000e-07 F a 2.700e-07 F.
Xao11 31 41 VCC 0 11 LM324
c11 31 VREF 2.700000000e-07
c21 21 11 2.700000000e-07
r31 IN 21 536.000000
r41 21 31 536.000000
r11 41 VREF 1870.000000
r21 41 11 3010.000000

* Stage 2: lowpass, f0=1106.25347 Hz, Q=0.89998, order=2
* Stage input: 11
* Stage output: 12
* Sallen-Key de componentes iguales con la relación del legado Av = 3 - 1/Q.
* Capacitor de la etapa ajustado de 1.000e-07 F a 2.700e-07 F.
Xao12 32 42 VCC 0 12 LM324
c12 32 VREF 2.700000000e-07
c22 22 12 2.700000000e-07
r32 11 22 536.000000
r42 22 32 536.000000
r12 42 VREF 2610.000000
r22 42 12 2320.000000

* Stage 3: lowpass, f0=1106.25347 Hz, Q=0.60134, order=2
* Stage input: 12
* Stage output: 13
* Sallen-Key de componentes iguales con la relación del legado Av = 3 - 1/Q.
* Capacitor de la etapa ajustado de 1.000e-07 F a 2.700e-07 F.
Xao13 33 43 VCC 0 13 LM324
c13 33 VREF 2.700000000e-07
c23 23 13 2.700000000e-07
r33 12 23 536.000000
r43 23 33 536.000000
r13 43 VREF 3400.000000
r23 43 13 1150.000000

* Stage 4: lowpass, f0=1106.25347 Hz, Q=0.50980, order=2
* Stage input: 13
* Stage output: OUT
* Sallen-Key de componentes iguales con la relación del legado Av = 3 - 1/Q.
* Capacitor de la etapa ajustado de 1.000e-07 F a 2.700e-07 F.
Xao14 34 44 VCC 0 OUT LM324
c14 34 VREF 2.700000000e-07
c24 24 OUT 2.700000000e-07
r34 13 24 536.000000
r44 24 34 536.000000
r14 44 VREF 1020.000000
r24 44 OUT 39.200000

* punto de operacion inicial en la tierra virtual
.nodeset V(11)=2.5 V(12)=2.5 V(13)=2.5 V(OUT)=2.5

.ac dec 100 100 20000
.probe V(OUT)
.end
