* Netlist capturado del SOFIA original (Sofia.exe) con scripts/legacy_capture.py
* El editor de SOFIA pega el modelo del opamp desde el portapapeles; aqui se referencia con .include
.include "../../../resources/models/oplm324.cir"
*polarizacion de tierra virtual
vin 10 0  dc 2.5 ac 1
vtierra 100 0 2.5V
*Primer Bicuadratico
Xao11 31 41 50 0 11 LM324
c11 31 100 1.000000e-07
c21 21 11 1.000000e-07
r31 10 21 1.500000e+03
r41 21 31 1.500000e+03
r11 41 100 1.000000e+03
r21 41 11 1.600000e+03
Xao12 32 42 50 0 12 LM324
c12 32 100 1.000000e-07
c22 22 12 1.000000e-07
r32 11 22 1.500000e+03
r42 22 32 1.500000e+03
r12 42 100 1.000000e+03
r22 42 12 9.100000e+02
Xao13 33 43 50 0 13 LM324
c13 33 100 1.000000e-07
c23 23 13 1.000000e-07
r33 12 23 1.500000e+03
r43 23 33 1.500000e+03
r13 43 100 1.000000e+03
r23 43 13 3.300000e+02
Xao14 34 44 50 0 14 LM324
c14 34 100 1.000000e-07
c24 24 14 1.000000e-07
r34 13 24 1.500000e+03
r44 24 34 1.500000e+03
r14 44 100 1.000000e+03
r24 44 14 3.900000e+01
*polarizacion del opamp
vdd 50 0 dc 5
.ac dec 100 1Hz 500Hz
.probe
.end
