* SOFIA Filter Studio generated netlist
* Topology request: sallen_key
* Filter kind: bandpass
* Approximation: butterworth
* Filter order: 8
* Epsilon: 0.50884714
.include "../../../resources/models/TL082.cir"

* polarizacion de tierra virtual: fuente unica de 15 V, tierra virtual en 7.5 V
Vin IN 0 DC 7.5 AC 1
VTIERRA VREF 0 7.5V
VCC VCC 0 DC 15
RLOAD OUT 0 100k

* Stage 1: bandpass, f0=1110.49456 Hz, Q=11.04610, order=2
* Stage input: IN
* Stage output: 11
* Equal-C, equal-R Sallen-Key band-pass with K = 4 - sqrt(2)/Q and center gain K/(4 - K).
* Q = 11.05 makes this Sallen-Key band-pass very sensitive to resistor tolerance and op amp bandwidth; MFB or Tow-Thomas is more robust.
* Input divider R1a/R1b (Thevenin = R1) scales the peak gain from 30.24 to 2.629.
Xao11 31 41 VCC 0 11 TL082
* R1a: parallel array for target 23316.872717 ohm
r31_1 IN 21 24000.000000
r31_2 IN 21 820000.000000
* R1b: series array for target 2219.793585 ohm
r61_1 21 r61_MID1 20.000000
r61_2 r61_MID1 VREF 2200.000000
c11 21 VREF 1.000000000e-07
c21 21 31 1.000000000e-07
* R2: series array for target 2026.836387 ohm
r41_1 21 r41_MID1 27.000000
r41_2 r41_MID1 11 2000.000000
* R3: series array for target 2026.836387 ohm
r51_1 31 r51_MID1 27.000000
r51_2 r51_MID1 VREF 2000.000000
r11 41 VREF 10000.000000
* Rf: parallel array for target 28719.716717 ohm
r21_1 41 11 30000.000000
r21_2 41 11 680000.000000

* Stage 2: bandpass, f0=1041.61676 Hz, Q=4.55276, order=2
* Stage input: 11
* Stage output: 12
* Equal-C, equal-R Sallen-Key band-pass with K = 4 - sqrt(2)/Q and center gain K/(4 - K).
* Input divider R1a/R1b (Thevenin = R1) scales the peak gain from 11.88 to 1.084.
* Stage capacitor auto-tuned from 1.000e-07 F to 1.000e-08 F.
Xao12 32 42 VCC 0 12 TL082
* R1a: parallel array for target 236863.998473 ohm
r32_1 11 22 240000.000000
r32_2 11 22 18000000.000000
* R1b: parallel array for target 23777.830539 ohm
r62_1 22 VREF 24000.000000
r62_2 22 VREF 2700000.000000
c12 22 VREF 1.000000000e-08
c22 22 32 1.000000000e-08
* R2: parallel array for target 21608.626819 ohm
r42_1 22 12 22000.000000
r42_2 22 12 1200000.000000
* R3: parallel array for target 21608.626819 ohm
r52_1 32 VREF 22000.000000
r52_2 32 VREF 1200000.000000
r12 42 VREF 10000.000000
* Rf: parallel array for target 26893.720111 ohm
r22_1 42 12 27000.000000
r22_2 42 12 6800000.000000

* Stage 3: bandpass, f0=950.44553 Hz, Q=4.55276, order=2
* Stage input: 12
* Stage output: 13
* Equal-C, equal-R Sallen-Key band-pass with K = 4 - sqrt(2)/Q and center gain K/(4 - K).
* Input divider R1a/R1b (Thevenin = R1) scales the peak gain from 11.88 to 1.084.
Xao13 33 43 VCC 0 13 TL082
* R1a: parallel array for target 25958.511278 ohm
r33_1 12 23 27000.000000
r33_2 12 23 680000.000000
* R1b: parallel array for target 2605.871243 ohm
r63_1 23 VREF 2700.000000
r63_2 23 VREF 75000.000000
c13 23 VREF 1.000000000e-07
c23 23 33 1.000000000e-07
* R2: parallel array for target 2368.142844 ohm
r43_1 23 13 2400.000000
r43_2 23 13 180000.000000
* R3: parallel array for target 2368.142844 ohm
r53_1 33 VREF 2400.000000
r53_2 33 VREF 180000.000000
r13 43 VREF 10000.000000
* Rf: parallel array for target 26893.720111 ohm
r23_1 43 13 27000.000000
r23_2 43 13 6800000.000000

* Stage 4: bandpass, f0=891.49468 Hz, Q=11.04610, order=2
* Stage input: 13
* Stage output: OUT
* Equal-C, equal-R Sallen-Key band-pass with K = 4 - sqrt(2)/Q and center gain K/(4 - K).
* Q = 11.05 makes this Sallen-Key band-pass very sensitive to resistor tolerance and op amp bandwidth; MFB or Tow-Thomas is more robust.
* Input divider R1a/R1b (Thevenin = R1) scales the peak gain from 30.24 to 2.629.
Xao14 34 44 VCC 0 OUT TL082
* R1a: parallel array for target 29044.772652 ohm
r34_1 13 24 30000.000000
r34_2 13 24 910000.000000
* R1b: series array for target 2765.096365 ohm
r64_1 24 r64_MID1 68.000000
r64_2 r64_MID1 VREF 2700.000000
c14 24 VREF 1.000000000e-07
c24 24 34 1.000000000e-07
* R2: parallel array for target 2524.738321 ohm
r44_1 24 OUT 2700.000000
r44_2 24 OUT 39000.000000
* R3: parallel array for target 2524.738321 ohm
r54_1 34 VREF 2700.000000
r54_2 34 VREF 39000.000000
r14 44 VREF 10000.000000
* Rf: parallel array for target 28719.716717 ohm
r24_1 44 OUT 30000.000000
r24_2 44 OUT 680000.000000

* punto de operacion inicial en la tierra virtual
.nodeset V(11)=7.5 V(12)=7.5 V(13)=7.5 V(OUT)=7.5

.ac dec 100 60 16000
.probe V(OUT)
.end
