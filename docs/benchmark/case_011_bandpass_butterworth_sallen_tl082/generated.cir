* SOFIA Filter Studio generated netlist
* Topology request: sallen_key
* Filter kind: bandpass
* Approximation: butterworth
* Filter order: 8
* Epsilon: 0.50884714
.include "../../../resources/models/TL082.cir"

* polarizacion de tierra virtual: fuente unica de 15 V, tierra virtual en 7.5 V
Vin IN 0 DC 7.5 AC 1
VTIERRA VREF 0 7.5V
VCC VCC 0 DC 15
RLOAD OUT 0 100k

* Stage 1: bandpass, f0=1128.24341 Hz, Q=9.66752, order=2
* Stage input: IN
* Stage output: 11
* Sallen-Key pasa banda de componentes iguales: K = 4 - sqrt(2)/Q y ganancia al centro K/(4 - K).
* Con Q = 9.67 este Sallen-Key pasa banda es muy sensible a la tolerancia de las resistencias y al ancho de banda del opamp; MFB o Tow-Thomas son más robustos.
* Divisor de entrada R1a/R1b (Thevenin = R1) que lleva la ganancia pico de 26.34 a 2.634.
* Capacitor de la etapa ajustado de 1.000e-07 F a 1.500e-07 F.
Xao11 31 41 VCC 0 11 TL082
r31 IN 21 13300.000000
r61 21 VREF 1470.000000
c11 21 VREF 1.500000000e-07
c21 21 31 1.500000000e-07
r41 21 11 1330.000000
r51 31 VREF 1330.000000
r11 41 VREF 3570.000000
r21 41 11 10200.000000

* Stage 2: bandpass, f0=1048.64192 Hz, Q=3.97848, order=2
* Stage input: 11
* Stage output: 12
* Sallen-Key pasa banda de componentes iguales: K = 4 - sqrt(2)/Q y ganancia al centro K/(4 - K).
* Divisor de entrada R1a/R1b (Thevenin = R1) que lleva la ganancia pico de 10.25 a 1.084.
* Capacitor de la etapa ajustado de 1.000e-07 F a 1.200e-07 F.
Xao12 32 42 VCC 0 12 TL082
r32 11 22 16900.000000
r62 22 VREF 2000.000000
c12 22 VREF 1.200000000e-07
c22 22 32 1.200000000e-07
r42 22 12 1780.000000
r52 32 VREF 1780.000000
r12 42 VREF 4020.000000
r22 42 12 10700.000000

* Stage 3: bandpass, f0=944.07823 Hz, Q=3.97848, order=2
* Stage input: 12
* Stage output: 13
* Sallen-Key pasa banda de componentes iguales: K = 4 - sqrt(2)/Q y ganancia al centro K/(4 - K).
* Divisor de entrada R1a/R1b (Thevenin = R1) que lleva la ganancia pico de 10.25 a 1.084.
Xao13 33 43 VCC 0 13 TL082
r33 12 23 22600.000000
r63 23 VREF 2670.000000
c13 23 VREF 1.000000000e-07
c23 23 33 1.000000000e-07
r43 23 13 2370.000000
r53 33 VREF 2370.000000
r13 43 VREF 4020.000000
r23 43 13 10700.000000

* Stage 4: bandpass, f0=877.47022 Hz, Q=9.66752, order=2
* Stage input: 13
* Stage output: OUT
* Sallen-Key pasa banda de componentes iguales: K = 4 - sqrt(2)/Q y ganancia al centro K/(4 - K).
* Con Q = 9.67 este Sallen-Key pasa banda es muy sensible a la tolerancia de las resistencias y al ancho de banda del opamp; MFB o Tow-Thomas son más robustos.
* Divisor de entrada R1a/R1b (Thevenin = R1) que lleva la ganancia pico de 26.34 a 2.634.
* Capacitor de la etapa ajustado de 1.000e-07 F a 1.800e-07 F.
Xao14 34 44 VCC 0 OUT TL082
r34 13 24 14300.000000
r64 24 VREF 1580.000000
c14 24 VREF 1.800000000e-07
c24 24 34 1.800000000e-07
r44 24 OUT 1430.000000
r54 34 VREF 1430.000000
r14 44 VREF 3570.000000
r24 44 OUT 10200.000000

* punto de operacion inicial en la tierra virtual
.nodeset V(11)=7.5 V(12)=7.5 V(13)=7.5 V(OUT)=7.5

.ac dec 100 60 16000
.probe V(OUT)
.end
