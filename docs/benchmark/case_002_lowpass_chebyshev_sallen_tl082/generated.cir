* SOFIA Filter Studio generated netlist
* Topology request: sallen_key
* Filter kind: lowpass
* Approximation: chebyshev
* Filter order: 5
* Epsilon: 0.50884714
.include "../../../resources/models/TL082.cir"

* polarizacion de tierra virtual: fuente unica de 15 V, tierra virtual en 7.5 V
Vin IN 0 DC 7.5 AC 1
VTIERRA VREF 0 7.5V
VCC VCC 0 DC 15
RLOAD OUT 0 100k

* Stage 1: lowpass, f0=994.14028 Hz, Q=5.55644, order=2
* Stage input: IN
* Stage output: 11
* Equal-C, equal-R Sallen-Key synthesis derived from the legacy gain/Q relation Av = 3 - 1/Q.
* Stage capacitor auto-tuned from 1.000e-07 F to 1.000e-09 F.
Xao11 31 41 VCC 0 11 TL082
c11 31 VREF 1.000000000e-09
c21 21 11 1.000000000e-09
r31 IN 21 160000.000000
r41 21 31 160000.000000
r11 41 VREF 10000.000000
* Rf: series array for target 18200.286937 ohm
r21_1 41 r21_MID1 200.000000
r21_2 r21_MID1 11 18000.000000

* Stage 2: lowpass, f0=655.20829 Hz, Q=1.39879, order=2
* Stage input: 11
* Stage output: 12
* Equal-C, equal-R Sallen-Key synthesis derived from the legacy gain/Q relation Av = 3 - 1/Q.
Xao12 32 42 VCC 0 12 TL082
c12 32 VREF 1.000000000e-07
c22 22 12 1.000000000e-07
* R1: series array for target 2429.074030 ohm
r32_1 11 r32_MID1 30.000000
r32_2 r32_MID1 22 2400.000000
* R2: series array for target 2429.074030 ohm
r42_1 22 r42_MID1 30.000000
r42_2 r42_MID1 32 2400.000000
r12 42 VREF 10000.000000
* Rf: parallel array for target 12850.974629 ohm
r22_1 42 12 13000.000000
r22_2 42 12 1100000.000000

* Stage 3: lowpass, f0=289.49334 Hz, Q=first-order, order=1
* Stage input: 12
* Stage output: OUT
* First-order passive RC section buffered by a voltage follower.
* Stage capacitor auto-tuned from 1.000e-07 F to 1.000e-09 F.
Xao13 23 OUT VCC 0 OUT TL082
* R1: parallel array for target 549770.652453 ohm
r13_1 12 23 560000.000000
r13_2 12 23 30000000.000000
c13 23 VREF 1.000000000e-09

* punto de operacion inicial en la tierra virtual
.nodeset V(11)=7.5 V(12)=7.5 V(OUT)=7.5

.ac dec 100 100 20000
.probe V(OUT)
.end
