* SOFIA Filter Studio generated netlist
* Topology request: sallen_key
* Filter kind: lowpass
* Approximation: chebyshev
* Filter order: 5
* Epsilon: 0.50884714
.include "../../../resources/models/TL082.cir"

* polarizacion de tierra virtual: fuente unica de 15 V, tierra virtual en 7.5 V
Vin IN 0 DC 7.5 AC 1
VTIERRA VREF 0 7.5V
VCC VCC 0 DC 15
RLOAD OUT 0 100k

* Stage 1: lowpass, f0=1012.79565 Hz, Q=4.70625, order=2
* Stage input: IN
* Stage output: 11
* Sallen-Key de componentes iguales con la relación del legado Av = 3 - 1/Q.
* Capacitor de la etapa ajustado de 1.000e-07 F a 2.200e-07 F.
Xao11 31 41 VCC 0 11 TL082
c11 31 VREF 2.200000000e-07
c21 21 11 2.200000000e-07
r31 IN 21 715.000000
r41 21 31 715.000000
r11 41 VREF 1070.000000
r21 41 11 1910.000000

* Stage 2: lowpass, f0=683.18228 Hz, Q=1.21259, order=2
* Stage input: 11
* Stage output: 12
* Sallen-Key de componentes iguales con la relación del legado Av = 3 - 1/Q.
* Capacitor de la etapa ajustado de 1.000e-07 F a 2.700e-07 F.
Xao12 32 42 VCC 0 12 TL082
c12 32 VREF 2.700000000e-07
c22 22 12 2.700000000e-07
r32 11 22 866.000000
r42 22 32 866.000000
r12 42 VREF 1130.000000
r22 42 12 1330.000000

* Stage 3: lowpass, f0=348.20472 Hz, Q=first-order, order=1
* Stage input: 12
* Stage output: OUT
* Sección RC pasiva de primer orden con seguidor de voltaje.
* Capacitor de la etapa ajustado de 1.000e-07 F a 2.700e-07 F.
Xao13 23 OUT VCC 0 OUT TL082
r13 12 23 1690.000000
c13 23 VREF 2.700000000e-07

* punto de operacion inicial en la tierra virtual
.nodeset V(11)=7.5 V(12)=7.5 V(OUT)=7.5

.ac dec 100 100 20000
.probe V(OUT)
.end
