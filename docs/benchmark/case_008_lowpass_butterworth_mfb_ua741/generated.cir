* SOFIA Filter Studio generated netlist
* Topology request: mfb
* Filter kind: lowpass
* Approximation: butterworth
* Filter order: 8
* Epsilon: 0.50884714
.include "../../../resources/models/ua741.cir"

* polarizacion de tierra virtual: fuente unica de 15 V, tierra virtual en 7.5 V
Vin IN 0 DC 7.5 AC 1
VTIERRA VREF 0 7.5V
VCC VCC 0 DC 15
RLOAD OUT 0 100k

* Stage 1: lowpass, f0=1106.25347 Hz, Q=2.56292, order=2
* Stage input: IN
* Stage output: 11
* MFB pasa bajas con ganancia 1 en DC: C1 es el siguiente valor E12 arriba de 8*Q^2*C2 y R1..R3 dan w0 y Q exactos.
* Capacitor de la etapa ajustado de 1.000e-07 F a 8.200e-08 F.
Xao11 VREF 31 VCC 0 11 uA741
c11 21 VREF 4.700000000e-06
c21 31 11 8.200000000e-08
r11 IN 21 243.000000
r21 21 11 243.000000
r31 21 31 221.000000

* Stage 2: lowpass, f0=1106.25347 Hz, Q=0.89998, order=2
* Stage input: 11
* Stage output: 12
* MFB pasa bajas con ganancia 1 en DC: C1 es el siguiente valor E12 arriba de 8*Q^2*C2 y R1..R3 dan w0 y Q exactos.
* Capacitor de la etapa ajustado de 1.000e-07 F a 5.600e-08 F.
Xao12 VREF 32 VCC 0 12 uA741
c12 22 VREF 3.900000000e-07
c22 32 12 5.600000000e-08
r12 11 22 1050.000000
r22 22 12 1050.000000
r32 22 32 909.000000

* Stage 3: lowpass, f0=1106.25347 Hz, Q=0.60134, order=2
* Stage input: 12
* Stage output: 13
* MFB pasa bajas con ganancia 1 en DC: C1 es el siguiente valor E12 arriba de 8*Q^2*C2 y R1..R3 dan w0 y Q exactos.
* Capacitor de la etapa ajustado de 1.000e-07 F a 3.900e-08 F.
Xao13 VREF 33 VCC 0 13 uA741
c13 23 VREF 1.200000000e-07
c23 33 13 3.900000000e-08
r13 12 23 2320.000000
r23 23 13 2320.000000
r33 23 33 1910.000000

* Stage 4: lowpass, f0=1106.25347 Hz, Q=0.50980, order=2
* Stage input: 13
* Stage output: OUT
* MFB pasa bajas con ganancia 1 en DC: C1 es el siguiente valor E12 arriba de 8*Q^2*C2 y R1..R3 dan w0 y Q exactos.
* Capacitor de la etapa ajustado de 1.000e-07 F a 3.900e-08 F.
Xao14 VREF 34 VCC 0 OUT uA741
c14 24 VREF 8.200000000e-08
c24 34 OUT 3.900000000e-08
r14 13 24 3240.000000
r24 24 OUT 3240.000000
r34 24 34 2000.000000

* punto de operacion inicial en la tierra virtual
.nodeset V(11)=7.5 V(12)=7.5 V(13)=7.5 V(OUT)=7.5

.ac dec 100 100 20000
.probe V(OUT)
.end
