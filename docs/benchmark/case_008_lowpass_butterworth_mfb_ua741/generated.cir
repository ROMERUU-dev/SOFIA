* SOFIA Filter Studio generated netlist
* Topology request: mfb
* Filter kind: lowpass
* Approximation: butterworth
* Filter order: 8
* Epsilon: 0.50884714
.include "../../../resources/models/ua741.cir"

* polarizacion de tierra virtual: fuente unica de 15 V, tierra virtual en 7.5 V
Vin IN 0 DC 7.5 AC 1
VTIERRA VREF 0 7.5V
VCC VCC 0 DC 15
RLOAD OUT 0 100k

* Stage 1: lowpass, f0=1088.11947 Hz, Q=2.56292, order=2
* Stage input: IN
* Stage output: 11
* MFB low-pass with unity DC gain: C1 is the next E12 value above 8*Q^2*C2 and R1..R3 solve w0 and Q exactly.
Xao11 VREF 31 VCC 0 11 uA741
c11 21 VREF 5.600000000e-06
c21 31 11 1.000000000e-07
* R1: parallel array for target 214.506972 ohm
r11_1 IN 21 240.000000
r11_2 IN 21 2000.000000
* R2: parallel array for target 214.506972 ohm
r21_1 21 11 240.000000
r21_2 21 11 2000.000000
* R3: series array for target 178.097432 ohm
r31_1 21 r31_MID1 18.000000
r31_2 r31_MID1 31 160.000000

* Stage 2: lowpass, f0=1088.11947 Hz, Q=0.89998, order=2
* Stage input: 11
* Stage output: 12
* MFB low-pass with unity DC gain: C1 is the next E12 value above 8*Q^2*C2 and R1..R3 solve w0 and Q exactly.
* Stage capacitor auto-tuned from 1.000e-07 F to 1.000e-08 F.
Xao12 VREF 32 VCC 0 12 uA741
c12 22 VREF 6.800000000e-08
c22 32 12 1.000000000e-08
* R1: series array for target 6362.363811 ohm
r12_1 11 r12_MID1 160.000000
r12_2 r12_MID1 22 6200.000000
* R2: series array for target 6362.363811 ohm
r22_1 22 r22_MID1 160.000000
r22_2 r22_MID1 12 6200.000000
* R3: parallel array for target 4944.924737 ohm
r32_1 22 32 5100.000000
r32_2 22 32 160000.000000

* Stage 3: lowpass, f0=1088.11947 Hz, Q=0.60134, order=2
* Stage input: 12
* Stage output: 13
* MFB low-pass with unity DC gain: C1 is the next E12 value above 8*Q^2*C2 and R1..R3 solve w0 and Q exactly.
* Stage capacitor auto-tuned from 1.000e-07 F to 1.000e-08 F.
Xao13 VREF 33 VCC 0 13 uA741
c13 23 VREF 3.300000000e-08
c23 33 13 1.000000000e-08
* R1: series array for target 7890.180703 ohm
r13_1 12 r13_MID1 390.000000
r13_2 r13_MID1 23 7500.000000
* R2: series array for target 7890.180703 ohm
r23_1 23 r23_MID1 390.000000
r23_2 r23_MID1 13 7500.000000
* R3: series array for target 8216.487677 ohm
r33_1 23 r33_MID1 16.000000
r33_2 r33_MID1 33 8200.000000

* Stage 4: lowpass, f0=1088.11947 Hz, Q=0.50980, order=2
* Stage input: 13
* Stage output: OUT
* MFB low-pass with unity DC gain: C1 is the next E12 value above 8*Q^2*C2 and R1..R3 solve w0 and Q exactly.
* Stage capacitor auto-tuned from 1.000e-07 F to 1.000e-09 F.
Xao14 VREF 34 VCC 0 OUT uA741
c14 24 VREF 2.200000000e-09
c24 34 OUT 1.000000000e-09
* R1: parallel array for target 109830.667135 ohm
r14_1 13 24 110000.000000
r14_2 13 24 75000000.000000
* R2: parallel array for target 109830.667135 ohm
r24_1 24 OUT 110000.000000
r24_2 24 OUT 75000000.000000
* R3: parallel array for target 88540.260479 ohm
r34_1 24 34 91000.000000
r34_2 24 34 3300000.000000

* punto de operacion inicial en la tierra virtual
.nodeset V(11)=7.5 V(12)=7.5 V(13)=7.5 V(OUT)=7.5

.ac dec 100 100 20000
.probe V(OUT)
.end
