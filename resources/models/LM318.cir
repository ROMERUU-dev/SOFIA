* connections:   non-inverting input
*                | inverting input
*                | | positive power supply
*                | | | negative power supply
*                | | | | output
*                | | | | |
.subckt LM318    1 2 3 4 5
*
  c1   11 12 2.887E-12
  c2    6  7 20.00E-12
  dc    5 53 dy
  de   54  5 dy
  dlp  90 91 dx
  dln  92 90 dx
  dp    4  3 dx
* SOFIA: los nodos de la fuente egnd van sin comas ni parentesis (mismo circuito) porque LTspice 24 las marca como error.
  egnd 99  0 poly(2) 3 0 4 0 0 .5 .5
  fb    7 99 poly(5) vb vc ve vlp vln 0 636.5E3 -1E3 1E3 600E3 -600E3
  ga    6  0 11 12 12.57E-3
  gcm   0  6 10 99 125.7E-9
  iee  10  4 dc 1.400E-3
  hlim 90  0 vlim 1K
  q1   11  2 13 qx
  q2   12  1 14 qx
  r2    6  9 100.0E3
  rc1   3 11 79.57
  rc2   3 12 79.57
  re1  13 10 42.61
  re2  14 10 42.61
  ree  10 99 142.8E3
  ro1   8  5 50
  ro2   7 99 25
  rp    3  4 9.678E3
  vb    9  0 dc 0
  vc    3 53 dc 2
  ve   54  4 dc 2
  vlim  7  8 dc 0
  vlp  91  0 dc 22
  vln   0 92 dc 22
.model dx D(Is=800.0E-18 Rs=1)
.model dy D(Is=800.00E-18 Rs=1m Cjo=10p)
.model qx NPN(Is=800.0E-18 Bf=4.667E3)
.ends
